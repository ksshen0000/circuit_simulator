* RC low-pass filter, fc approximately 159 Hz
V1 in 0 DC 0 AC 1
R1 in out 1k
C1 out 0 1u
.ac dec 20 1 100k
.end
