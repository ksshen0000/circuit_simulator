* Voltage follower with 1uF capacitive load and 10k resistive load
V1 in 0 DC 0 AC 1
XU1 in out out CS_OPAMP
CL out 0 1u
RL out 0 10k
.ac dec 30 10 1meg
.end
